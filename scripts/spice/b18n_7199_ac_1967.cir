* B-18N/B-15ND 1967 - V3 (7199): respuesta AC del inversor
*
* Mismas condiciones y modelos que b18n_7199_meter_loading.cir (Koren RCA,
* carriles 380/460 V, red de rejilla 10M/3.3M). Excitacion AC de 1 V en la
* rejilla del pentodo (pin 7). Las salidas se miden tras el acoplo de 0.05 uF
* con el retorno de rejilla de la 7027A (100 kOhm a masa en AC), que es la
* tension que recibe `process_grids` en el motor.
*
* Golden: assets/fixtures/reference/phase_7199/b18n_7199_ac_1967_golden.csv
* (generado por scripts/spice/phase_inverter_reference.py).

.param meter=1e12

* --- Carriles ---
vp rail_p 0 dc 380
vt rail_t 0 dc 460

* --- Pentodo: alimentacion y red de catodo/pantalla ---
r270 rail_p pin2 270k
r470 rail_p pin3 470k
r150 pin3 0 150k
c01 pin3 pin6 0.1u
r15 pin6 0 1.5k
rg7 pin7 0 5.6meg

* --- Acoplo y polarizacion de la rejilla del triodo ---
c02 pin2 pin9 0.02u
r10m pin1 pin9 10meg
r33m pin9 0 3.3meg

* --- Triodo inversor de carga dividida ---
r47p rail_t pin1 47k
r47k pin8 0 47k

* --- Realimentacion negativa: 22 k desde la toma de 16 ohm (AC) ---
rfb pin6 0 22k

* --- Valvulas (Koren; mismas ecuaciones que el DSP) ---
xpent pin2 pin3 pin7 pin6 k7199p
xtri pin1 pin9 pin8 k7199t

.subckt k7199p p g2 g k params: mu=22.2795 ex=1.63827 kg1=3712.07 kp=66.5138 kvb=12.5222 kg2=3807.56
Bvp vp 0 V = {max(v(p,k),0)}
Be1 e1 0 V = {v(g2,k)/kp*ln(1+exp(kp*(1/mu+v(g,k)/v(g2,k))))}
Bip p k I = {2*pwr(max(v(e1),0),ex)/kg1*atan(v(vp)/kvb)}
Big2 g2 k I = {pwr(max(v(g2,k)/mu+v(g,k),0),ex)/kg2}
.ends

.subckt k7199t p g k params: mu=17 ex=0.978282 kg1=448.917 kp=272.472 kvb=160
Bvp vp 0 V = {max(v(p,k),0)}
Be1 e1 0 V = {v(vp)/kp*ln(1+exp(kp*(1/mu+v(g,k)/sqrt(kvb+v(vp)*v(vp)))))}
Bip p k I = {pwr(max(v(e1),0),ex)/kg1}
.ends

* --- Excitacion AC unitaria en la rejilla del pentodo ---
vgrid pin7 0 dc 0 ac 1

.control
set numdgt=10
ac lin 1 20 20
let hu = v(pin1)
let hd = v(pin8)
print mag(hu) ph(hu) mag(hd) ph(hd)
ac lin 1 50 50
let hu = v(pin1)
let hd = v(pin8)
print mag(hu) ph(hu) mag(hd) ph(hd)
ac lin 1 100 100
let hu = v(pin1)
let hd = v(pin8)
print mag(hu) ph(hu) mag(hd) ph(hd)
ac lin 1 200 200
let hu = v(pin1)
let hd = v(pin8)
print mag(hu) ph(hu) mag(hd) ph(hd)
ac lin 1 500 500
let hu = v(pin1)
let hd = v(pin8)
print mag(hu) ph(hu) mag(hd) ph(hd)
ac lin 1 1000 1000
let hu = v(pin1)
let hd = v(pin8)
print mag(hu) ph(hu) mag(hd) ph(hd)
ac lin 1 2000 2000
let hu = v(pin1)
let hd = v(pin8)
print mag(hu) ph(hu) mag(hd) ph(hd)
ac lin 1 5000 5000
let hu = v(pin1)
let hd = v(pin8)
print mag(hu) ph(hu) mag(hd) ph(hd)
ac lin 1 10000 10000
let hu = v(pin1)
let hd = v(pin8)
print mag(hu) ph(hu) mag(hd) ph(hd)
ac lin 1 20000 20000
let hu = v(pin1)
let hd = v(pin8)
print mag(hu) ph(hu) mag(hd) ph(hd)
.endc
.end
